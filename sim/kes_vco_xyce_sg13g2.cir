* Kestrel VCO — Transistor-level range characterization (Xyce)
* IHP SG13G2 / SG13CMOS5L — 130nm SiGe BiCMOS, 1.2V low-voltage CMOS
*
* 4-stage differential Maneatis ring oscillator
* Sweep Vctrl from 0.2V to 1.0V, measure oscillation frequency
*

**********************************************************************
* Process models — IHP SG13G2 low-voltage CMOS (PSP 103, TT corner)
*
* Xyce-native level-103 cards flattened from IHP-Open-PDK's mos_tt
* section (see models/sg13g2_lv.lib for provenance and why the PDK's
* own Xyce library, which needs the YPSP103_VA device, is not used).
* Run from the sim/ directory:  Xyce kes_vco_xyce_sg13g2.cir
* The 17-point sweep takes ~16 min (PSP103 is ~30x slower than the
* sky130 BSIM4 deck); frequencies come from the .mt0 / .prn output.
**********************************************************************
.include "models/sg13g2_psp103_tt.lib"

**********************************************************************
* VCO subcircuits
**********************************************************************

* Maneatis delay cell — differential pair + symmetric load
.SUBCKT kestrel_delay_cell outp outn inp inn vctrl vbn vdd vss

* Tail current source (L=0.5u for analog matching)
Mtail  tail  vbn  vss  vss  sg13g2_nmos W=4u L=0.5u

* Differential pair — sized for gm > gm_load to ensure oscillation
Mn1    outn  inp  tail vss  sg13g2_nmos W=2u L=0.34u
Mn2    outp  inn  tail vss  sg13g2_nmos W=2u L=0.34u

* Symmetric load (Maneatis) — diode + Vctrl-controlled PFET pair
Mp1a   outn  outn vdd  vdd  sg13g2_pmos W=3u L=0.5u
Mp1b   outn  vctrl vdd vdd  sg13g2_pmos W=3u L=0.5u
Mp2a   outp  outp vdd  vdd  sg13g2_pmos W=3u L=0.5u
Mp2b   outp  vctrl vdd vdd  sg13g2_pmos W=3u L=0.5u

.ENDS kestrel_delay_cell

* Self-biased replica bias generator (Maneatis)
* vbn is the replica output — negative feedback loop
.SUBCKT kestrel_vco_bias vbn vctrl vdd vss

* Diode NFET — mirrors tail current
Mrep_n   vbn  vbn  vss  vss  sg13g2_nmos W=2u L=0.5u
* Diode PFET load (matches Xp1a/Xp2a in delay cell)
Mrep_pd  vbn  vbn  vdd  vdd  sg13g2_pmos W=3u L=0.5u
* Vctrl-controlled PFET load (matches Xp1b/Xp2b in delay cell)
Mrep_pc  vbn  vctrl vdd vdd  sg13g2_pmos W=3u L=0.5u
* Startup current to avoid degenerate vbn=0 solution
Istart vdd vbn 5u

.ENDS kestrel_vco_bias

* Ring oscillator VCO — 4-stage differential
.SUBCKT kestrel_vco outp outn vctrl_ext vdd vss

Xbias vbn vctrl_int vdd vss kestrel_vco_bias
Rsw vctrl_ext vctrl 1
Rbias vctrl_int vctrl 100k

Xstage0 dp_0 dn_0 dn_3 dp_3 vctrl vbn vdd vss kestrel_delay_cell
Xstage1 dp_1 dn_1 dp_0 dn_0 vctrl vbn vdd vss kestrel_delay_cell
Xstage2 dp_2 dn_2 dp_1 dn_1 vctrl vbn vdd vss kestrel_delay_cell
Xstage3 dp_3 dn_3 dp_2 dn_2 vctrl vbn vdd vss kestrel_delay_cell

Routp dp_3 outp 1
Routn dn_3 outn 1

.ENDS kestrel_vco

**********************************************************************
* Testbench
**********************************************************************
Vdd vdd 0 1.2
Vss vss 0 0

* Sweep control voltage via .STEP
Vctrl vctrl 0 {vctrl_val}
.PARAM vctrl_val = 0.6

Xvco outp outn vctrl vdd vss kestrel_vco

* Small cap load
Cload_p outp 0 10f
Cload_n outn 0 10f

* Differential output for frequency measurement
Ediff diff 0 outp outn 1.0

* Startup kick — inject asymmetric current to break symmetry
Ikick 0 Xvco:dp_0 PULSE(0 1m 0 50p 50p 10n 0)

**********************************************************************
* Transient analysis
**********************************************************************
.TRAN 50p 500n

* Print output waveform + bias voltage
.PRINT TRAN V(outp) V(outn) V(vctrl) V(Xvco:vbn) V(diff)

* Measure frequency from differential zero crossings
.MEASURE TRAN t1 WHEN V(diff)=0 RISE=3 TD=50n
.MEASURE TRAN t2 WHEN V(diff)=0 RISE=4 TD=50n
* f_vco = 1/(t2-t1), computed from measure output file

* Step Vctrl for range sweep (1.2V supply, so sweep up to ~1.0V)
.STEP vctrl_val 0.2 1.0 0.05

* Measured 2026-11-11 (Xyce 7.10-dev, native PSP103, sizing above):
*  Vctrl 0.20 0.25 0.30 0.35 0.40 0.45 0.50 0.55 0.60 0.65 0.70 0.75 0.80 0.85 0.90 0.95
*  MHz   1099 1019  942  867  795  728  673  639  654  702  734  756  769  775  779  779
* 0.2-0.55 V is the classic Maneatis region (f falls as Vctrl rises,
* Kvco ~ -1.3 GHz/V).  Above ~0.55 V the Vctrl PFET is off, the replica
* bias dominates and f rises again, saturating near 780 MHz.  Kvco
* therefore changes sign at ~0.55 V: close a loop around one side only
* (0.2-0.5 V, inverted charge-pump polarity) or resize before use.
* NOTE: these M-cards carry no AS/AD/PS/PD, i.e. no junction parasitics.
* The same sizing emitted by `kestrel pll gen --process sg13g2` (X-instances
* of the sg13_lv_* wrappers, IHP default S/D areas) runs ~20% slower in
* Xyce: 844 MHz @ 0.20 V to 517 MHz @ 0.50 V.
* 2026-11-12: Xyce's built-in level-103 is the outlier.  With the PDK's own
* PSP103 (psp103.va on the PDK's cards; VACASK through vamos and ngspice
* OSDI agree within 1 %) the generated VCO runs ~45 % faster — 1579 MHz at
* 0 V, 1299 @ 0.15, 1209 @ 0.20, 954 @ 0.35, 812 @ 0.45, minimum 733 @ 0.55,
* 965 MHz floor above 0.9 V — and that VACASK curve (0.15-0.45 V window,
* Kvco -1.634 GHz/V) is the one recorded in kestrel/process.py as the
* sg13g2 calibration.  Sweep it on VACASK with
* `spectre -I<pdk>/verilog-a/psp103 -I<pdk>/ngspice/models` over the
* generated kestrel_vco.sp (one run per Vctrl, ~8 s each).

.END
