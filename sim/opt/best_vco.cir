* Kestrel VCO — optimization run (auto-generated)
*
**********************************************************************
* Process models
**********************************************************************
.PARAM sky130_fd_pr__nfet_01v8__toxe_slope = 0.0
.PARAM sky130_fd_pr__nfet_01v8__vth0_slope = 0.0
.PARAM sky130_fd_pr__nfet_01v8__voff_slope = 0.0
.PARAM sky130_fd_pr__nfet_01v8__vth0_slope1 = 0.0
.PARAM sky130_fd_pr__pfet_01v8__toxe_slope = 0.0
.PARAM sky130_fd_pr__pfet_01v8__vth0_slope = 0.0
.PARAM sky130_fd_pr__pfet_01v8__voff_slope = 0.0
.PARAM sky130_fd_pr__pfet_01v8__nfactor_slope = 0.0
.PARAM sky130_fd_pr__pfet_01v8__toxe_slope1 = 0.0
.PARAM sky130_fd_pr__pfet_01v8__vth0_slope1 = 0.0
.PARAM sky130_fd_pr__pfet_01v8__voff_slope1 = 0.0
.PARAM sky130_fd_pr__pfet_01v8__nfactor_slope1 = 0.0
.PARAM sky130_fd_pr__pfet_01v8__wlod_diff = 0.0
.PARAM sky130_fd_pr__pfet_01v8__kvth0_diff = 0.0
.PARAM sky130_fd_pr__pfet_01v8__ku0_diff = 0.0
.PARAM sky130_fd_pr__pfet_01v8__kvsat_diff = 0.0
.PARAM sky130_fd_pr__pfet_01v8__lkvth0_diff = 0.0
.PARAM sky130_fd_pr__pfet_01v8__wkvth0_diff = 0.0
.PARAM sky130_fd_pr__pfet_01v8__lku0_diff = 0.0
.PARAM sky130_fd_pr__pfet_01v8__wku0_diff = 0.0

.INCLUDE "models/sky130_nfet_xyce.spice"
.INCLUDE "models/sky130_pfet_xyce.spice"

**********************************************************************
* VCO subcircuits
**********************************************************************

.SUBCKT kestrel_delay_cell outp outn inp inn vctrl vbn vdd vss
Mtail  tail  vbn  vss  vss  sky130_fd_pr__nfet_01v8__model.6 W=3.9791e-05 L=0.360u
Mn1    outn  inp  tail vss  sky130_fd_pr__nfet_01v8__model.6 W=9.8738e-06 L=0.360u
Mn2    outp  inn  tail vss  sky130_fd_pr__nfet_01v8__model.6 W=9.8738e-06 L=0.360u
Mp1a   outn  outn vdd  vdd  sky130_fd_pr__pfet_01v8__model.6 W=1.5279e-05 L=0.360u
Mp1b   outn  vctrl vdd vdd  sky130_fd_pr__pfet_01v8__model.6 W=9.0239e-06 L=0.360u
Mp2a   outp  outp vdd  vdd  sky130_fd_pr__pfet_01v8__model.6 W=1.5279e-05 L=0.360u
Mp2b   outp  vctrl vdd vdd  sky130_fd_pr__pfet_01v8__model.6 W=9.0239e-06 L=0.360u
.ENDS kestrel_delay_cell

.SUBCKT kestrel_vco_bias vbn vctrl vdd vss
Mrep_n   vbn  vbn  vss  vss  sky130_fd_pr__nfet_01v8__model.6 W=1.9478e-05 L=0.360u
Mrep_pd  vbn  vbn  vdd  vdd  sky130_fd_pr__pfet_01v8__model.6 W=1.5279e-05 L=0.360u
Mrep_pc  vbn  vctrl vdd vdd  sky130_fd_pr__pfet_01v8__model.6 W=9.0239e-06 L=0.360u
Istart vdd vbn 5.5308e-06
.ENDS kestrel_vco_bias

.SUBCKT kestrel_vco outp outn vctrl_ext vdd vss
Xbias vbn vctrl_int vdd vss kestrel_vco_bias
Rsw vctrl_ext vctrl 1
Rbias vctrl_int vctrl 100k
Xstage0 dp_0 dn_0 dn_3 dp_3 vctrl vbn vdd vss kestrel_delay_cell
Xstage1 dp_1 dn_1 dp_0 dn_0 vctrl vbn vdd vss kestrel_delay_cell
Xstage2 dp_2 dn_2 dp_1 dn_1 vctrl vbn vdd vss kestrel_delay_cell
Xstage3 dp_3 dn_3 dp_2 dn_2 vctrl vbn vdd vss kestrel_delay_cell
Routp dp_3 outp 1
Routn dn_3 outn 1
.ENDS kestrel_vco

**********************************************************************
* Testbench
**********************************************************************
Vdd vdd 0 1.8
Vss vss 0 0
Vctrl vctrl 0 {vctrl_val}
.PARAM vctrl_val = 0.9

Xvco outp outn vctrl vdd vss kestrel_vco

Cload_p outp 0 10f
Cload_n outn 0 10f
Ediff diff 0 outp outn 1.0
Ikick 0 Xvco:dp_0 PULSE(0 1m 0 50p 50p 10n 0)

.TRAN 50p 5e-07
.PRINT TRAN V(outp) V(outn) V(diff)
.MEASURE TRAN t1 WHEN V(diff)=0 RISE=3 TD=5e-08
.MEASURE TRAN t2 WHEN V(diff)=0 RISE=4 TD=5e-08
.STEP vctrl_val LIST 0.3 0.5 0.7 0.9 1.0 1.1 1.3 1.5

.END
