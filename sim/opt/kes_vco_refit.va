// kes_vco_refit — Behavioral VCO refit to match transistor-level layout
//
// Polynomial frequency model fit from optimization:
//   f(Vctrl) = 2.923e+09*Vctrl^3 + -1.062e+10*Vctrl^2 + 1.267e+10*Vctrl^1 + -4.185e+09*Vctrl^0
//
// Linear approximation: kvco_eff = 2.982e+08 Hz/V
//
// Generated by optimize_vco.py

`include "constants.vams"
`include "disciplines.vams"

module kes_vco(vctrl, outp, outn);
    inout  vctrl, outp, outn;
    electrical vctrl, outp, outn;
    electrical x, y;

    parameter real vdd = 1.8;
    parameter real mu  = 3.0;    // Van der Pol damping

    real omega;

    analog begin
        // Polynomial frequency model (refit from transistor-level data)
        omega = 6.283185307 * (2.922906e+09 * V(vctrl)*V(vctrl)*V(vctrl) + -1.061517e+10 * V(vctrl)*V(vctrl) + 1.266532e+10 * V(vctrl) + -4.185111e+09);

        // Clamp omega to positive values
        if (omega < 6.283185307 * 1e6) omega = 6.283185307 * 1e6;

        // Van der Pol oscillator
        I(x) <+ ddt(V(x)) - omega * V(y);
        I(y) <+ ddt(V(y)) - omega * (mu * (1.0 - V(x)*V(x)) * V(y) - V(x) + 0.01);

        // Output: scale to rail-to-rail
        V(outp) <+ 0.5 * vdd * (1.0 + tanh(5.0 * V(x)));
        V(outn) <+ vdd - V(outp);
    end
endmodule
