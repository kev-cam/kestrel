// kes_vco_refit.vams — behavioral VCO refit to the transistor-level curve
//
// Event-driven ring model (delay to next edge): one process is the edge
// travelling round n_stages delay cells; entering a stage it reads V(vctrl)
// and waits td = 1/(2*n_stages*f(V)); the output toggles once round.  The
// polynomial below is the fitted delay-vs-voltage law, valid for
// 0.70-1.50 V (outside it the frequency is the polynomial's value,
// floored at f_floor — check before relying on it):
//   f(Vctrl) = 2.923e+09*Vctrl^3 + -1.062e+10*Vctrl^2 + 1.267e+10*Vctrl^1 + -4.185e+09*Vctrl^0
// Linear approximation: kvco_eff = 2.982e+08 Hz/V
//
// Generated by optimize_vco.py --refit

`include "constants.vams"
`include "disciplines.vams"
`timescale 1ps / 1fs

module kes_vco_refit(vctrl, clk_out, clk_outb);
    input  vctrl;
    output clk_out, clk_outb;
    electrical vctrl;
    reg    clk_out;
    wire   clk_outb;

    parameter integer n_stages = 4;
    parameter real    f_floor  = 4.766000e+07;   // Hz — slowest the ring may run
    localparam real   TU       = 1e-12;             // s per `timescale unit

    integer stage;
    real    v, f, td;

    initial begin
        clk_out = 1'b0;
        stage   = 0;
    end

    assign clk_outb = ~clk_out;

    always begin
        v  = V(vctrl);
        f  = 2.922906e+09 * v * v * v + -1.061517e+10 * v * v + 1.266532e+10 * v + -4.185111e+09;
        if (f < f_floor) f = f_floor;
        td = 1.0 / (2.0 * n_stages * f);
        if (td < TU) td = TU;
        #(td / TU);
        stage = stage + 1;
        if (stage >= n_stages) begin
            stage   = 0;
            clk_out = ~clk_out;
        end
    end
endmodule
